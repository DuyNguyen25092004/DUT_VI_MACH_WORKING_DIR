ADE simulation setup
Test TC_TCBJT_1: TC/TCBJT/schematic, simulator spectre
  Models: /home/dtvt_13/CDNS_Client/sky130_release_0.1.0/libs/sky130_fd_pr_main/../../models/sky130.lib.spice[tt]
  Temperature: 27
  Analysis dc: sweep temperature start=-40 stop=125
  Output deriv(VS("/Vout"))
  Signals: /Vout
Run mode: Single Run, Sweeps and Corners
