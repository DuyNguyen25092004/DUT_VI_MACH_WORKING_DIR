ADE simulation setup
Run mode: Single Run, Sweeps and Corners
Tests:
  TC_TCBJT_1: TC/TCBJT/schematic, simulator spectre
