ADE simulation setup
Test mydesign_core_1: mydesign/core/schematic, simulator spectre
  Models: /home/dtvt_13/CDNS_Client/sky130_release_0.1.0/models/sky130.lib.spice[tt]
  Temperature: 27
  Analysis dc: sweep temperature start=-40 stop=125 (saves the operating point)
  Signals: /Vout
Run mode: Single Run, Sweeps and Corners
