ADE simulation setup
Run mode: Single Run, Sweeps and Corners
Tests:
  mydesign_core_1: mydesign/core/schematic, simulator spectre
