ADE simulation setup
Run mode: Single Run, Sweeps and Corners
Tests:
  bandgapcore_bgr_1: bandgapcore/bgr/schematic, simulator spectre
