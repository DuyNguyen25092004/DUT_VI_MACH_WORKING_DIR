ADE simulation setup
Test bandgapcore_bgr_1: bandgapcore/bgr/schematic, simulator spectre
  Models: /home/dtvt_16/CDNS_Client/sky130_release_0.1.0/models/sky130.lib.spice[tt]
  Temperature: 27
  Analysis dc: sweep temperature start=-40 stop=125 (saves the operating point)
  Output (VS("/V1") - VS("/V2"))
  Signals: /V1, /V2
Run mode: Single Run, Sweeps and Corners
