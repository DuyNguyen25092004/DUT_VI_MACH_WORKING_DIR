ADE simulation setup
Run mode: Single Run, Sweeps and Corners
Tests:
  gmIdwl_NMOS_1: gmIdwl/NMOS/schematic, simulator spectre
    Variables: length = 150n; vgs = 0.5; width = 480n
