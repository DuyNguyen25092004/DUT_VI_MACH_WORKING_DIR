ADE simulation setup
Test gmIdwl_NMOS_1: gmIdwl/NMOS/schematic, simulator spectre
  Models: /home/dtvt_13/CDNS_Client/sky130_release_0.1.0/models/sky130.lib.spice[tt]
  Variables: length = 150n; vgs = 0.5; width = 480n
  Temperature: 27
  Operating points saved: /NM0 (id gm vth vgs); /V2 (v)
  Analysis dc: sweep vgs start=0 stop=1.8 step=100u (saves the operating point)
  Output gmid vs Vod = waveVsWave(?x (OS("/NM0" "vgs") - OS("/NM0" "vth")) ?y (OS("/NM0" "gm") / OS("/NM0" "id")))
  Output gmid vs idW = waveVsWave(?x (OS("/NM0" "id") / OS("/V2" "v")) ?y (OS("/NM0" "gm") / OS("/NM0" "id")))
Run mode: Single Run, Sweeps and Corners
