ADE simulation setup
Test gmIdwl_gmid_1: gmIdwl/gmid/schematic, simulator spectre
  Models: /home/dtvt_13/CDNS_Client/sky130_release_0.1.0/models/sky130.lib.spice[tt]
  Variables: vsg = 0.5; length = 180n; width = 540n
  Temperature: 27
  Operating points saved: /PM0 (is ids vth vgs id gm); /V1 (v)
  Analysis dc: sweep vsg start=0 stop=1.8 step=100u (saves the operating point)
  Output waveVsWave(?x (OS("/PM0" "id") / OS("/V1" "v")) ?y (OS("/PM0" "gm") / OS("/PM0" "id"))) (unticked)
  Output waveVsWave(?x OS("/PM0" "vth") ?y (OS("/PM0" "gm") / OS("/PM0" "id")))
Run mode: Single Run, Sweeps and Corners
