ADE simulation setup
Run mode: Single Run, Sweeps and Corners
Tests:
  gmIdwl_gmid_1: gmIdwl/gmid/schematic, simulator spectre
    Variables: length = 180n; width = 540n; vsg = 0.5
    Outputs: waveVsWave(?x (OS("/PM0" "vth") - OS("/PM0" "vgs")) ?y (OS("/PM0" "gm") / OS("/PM0" "is"))); waveVsWave(?x (OS("/PM0" "vth") - OS("/PM0" "vgs")) ?y (OS("/PM0" "gm") / OS("/PM0" "ids")))
