ADE simulation setup
Run mode: Single Run, Sweeps and Corners
Tests:
  gmIdwl_WL_1: gmIdwl/WL/schematic, simulator spectre
    Variables: vsg = 500m
    Outputs: /PM0/S
