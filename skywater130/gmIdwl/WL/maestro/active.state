ADE simulation setup
Test gmIdwl_WL_1: gmIdwl/WL/schematic, simulator spectre
  Models: /home/dtvt_13/CDNS_Client/sky130_release_0.1.0/models/sky130.lib.spice[tt]
  Variables: vsg = 500m
  Temperature: 27
  Analysis dc: sweep vsg start=0 stop=1.8 (saves the operating point)
  Signals: /Vout, /PM0/S (terminal)
Run mode: Single Run, Sweeps and Corners
