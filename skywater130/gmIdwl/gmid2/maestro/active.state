ADE simulation setup
Test gmIdwl_gmid2_1: gmIdwl/gmid2/schematic, simulator spectre
  Models: /home/dtvt_13/CDNS_Client/sky130_release_0.1.0/models/sky130.lib.spice[tt]
  Variables: length = 180n; vsg = 0.6; width = 550n
  Temperature: 27
  Operating points saved: /PM0 (id gm vgs vth); /V2 (v)
  Analysis dc: sweep vsg start=0 stop=0.934 step=100u (saves the operating point)
  Output Vov = waveVsWave(?x (abs(OS("/PM0" "vgs")) - abs(OS("/PM0" "vth"))) ?y (OS("/PM0" "gm") / OS("/PM0" "id")))
  Output gm = waveVsWave(?x (abs(OS("/PM0" "vgs")) - abs(OS("/PM0" "vth"))) ?y OS("/PM0" "gm")) (unticked)
  Output id = waveVsWave(?x (abs(OS("/PM0" "vgs")) - abs(OS("/PM0" "vth"))) ?y OS("/PM0" "id")) (unticked)
  Output Idw = waveVsWave(?x (OS("/PM0" "id") / OS("/V2" "v")) ?y (OS("/PM0" "gm") / OS("/PM0" "id")))
Run mode: Single Run, Sweeps and Corners
