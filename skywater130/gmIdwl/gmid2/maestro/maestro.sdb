ADE simulation setup
Run mode: Single Run, Sweeps and Corners
Tests:
  gmIdwl_gmid2_1: gmIdwl/gmid2/schematic, simulator spectre
    Variables: length = 180n; vsg = 0.6; width = 550n
    Outputs: waveVsWave(?x OS("/PM0" "gm") ?y OS("/PM0" "id")); gm; waveVsWave(?x ((absOS "/PM0" "vgs") - OS("/PM0" "vth")) ?y OS("/PM0" "id")); nil; waveVsWave(?x ((abs OS "/PM0" "vgs") - abs(OS("/PM0" "vth"))) ?y OS("/PM0" "id")); id
