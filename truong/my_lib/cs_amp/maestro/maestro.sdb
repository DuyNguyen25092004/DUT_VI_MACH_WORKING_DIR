ADE simulation setup
Run mode: Single Run, Sweeps and Corners
Tests:
  my_lib_cs_amp_1: my_lib/cs_amp/schematic, simulator spectre
