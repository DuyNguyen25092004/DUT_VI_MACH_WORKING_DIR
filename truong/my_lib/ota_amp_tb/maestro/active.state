ADE simulation setup
Test my_lib_ota_amp_tb_1: my_lib/ota_amp_tb/schematic, simulator spectre
  Models: /home/dtvt_05/Downloads/65NTSMC/models/spectre/crn65gplus_2d5_lk_v1d0.scs[tt_rfmos_18]
  Variables: W_PM1_M2 = 8u; L_NM3_M4 = 380n; L_PM1_M2 = 380n; W_NM3_M4 = 900n
  Temperature: 27
  Analysis dc: (saves the operating point)
  Analysis ac: start=1 stop=100G
  Output dB20(VF("/Vout"))
  Output dB20((VF("/Vout") / (VF("/vin+") - VF("/vin-"))))
  Signals: /Vout, /vin+, /vin-
Run mode: Single Run, Sweeps and Corners
