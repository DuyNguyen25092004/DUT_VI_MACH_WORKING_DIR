ADE simulation setup
Test my_lib_ota_amp_tb_1: my_lib/ota_amp_tb/schematic, simulator spectre
  Models: /home/dtvt_13/WORK/65NTSMC/tsmcN65/../models/spectre/crn65gplus_2d5_lk_v1d0.scs[tt_bip, tt_dio, tt_dio_33, tt_mim, tt_dio_dnw, tt_dio_18, tt_bip_npn, tt_33, tt_rfrtmom, tt_mos_cap_25, tt_18, tt_disres, tt_res, tt_dio_na, tt_rfmos_33, tt_dio_hvt, tt_rfmvar, tt_rfmos_18, tt_na, tt_dio_na33, tt_dio_lvt, tt_rfres_sa, tt_na33, tt_dio_esd, tt_rfmim, tt_dio_25od33, tt_25od33, tt, tt_mos_cap, tt_dio_25, tt_dio_25ud18, tt_25, tt_rfmos, tt_25ud18, tt_dio_na25od33, tt_rfjvar, tt_rfmos_25, tt_rtmom, tt_na25od33, tt_dio_na25, tt_rfres_rpo, tt_hvt, tt_rfind, tt_rfmvar_25, tt_na25, tt_lvt]
  Temperature: 27
  Analysis ac: start=1 stop=100G
  Analysis dc: (saves the operating point)
  Output dB20(VF("/Vout"))
  Output dB20((VF("/Vout") / (VF("/vin+") - VF("/vin-"))))
  Signals: /Vout, /vin+, /vin-
Run mode: Single Run, Sweeps and Corners
