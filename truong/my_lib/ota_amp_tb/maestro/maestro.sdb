ADE simulation setup
Run mode: Single Run, Sweeps and Corners
Tests:
  my_lib_ota_amp_tb_1: my_lib/ota_amp_tb/schematic, simulator spectre
    Outputs: nil; dB20(VF(("/Vout"))); dB20(VF("/Vout"))
