ADE simulation setup
Run mode: Single Run, Sweeps and Corners
Tests:
  my_lib_ota_amp_tb_1: my_lib/ota_amp_tb/schematic, simulator spectre
    Variables: L_NM3_M4 = 380n; W_NM3_M4 = 900n; L_PM1_M2 = 380n; W_PM1_M2 = 8u
    Outputs: nil; dB20(VF(("/Vout"))); dB20(VF("/Vout"))
