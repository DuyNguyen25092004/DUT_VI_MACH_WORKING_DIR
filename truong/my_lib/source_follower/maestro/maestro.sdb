ADE simulation setup
Run mode: Single Run, Sweeps and Corners
Tests:
  my_lib_source_follower_1: my_lib/source_follower/schematic, simulator spectre
