ADE simulation setup
Run mode: Single Run, Sweeps and Corners
Tests:
  my_lib_nmos_tb_1: my_lib/nmos_tb/schematic, simulator spectre
    Variables: l_sweep = 0.26u:0.012u:0.38u; mul = 1; vg = 900m; vs = 1.8; w_sweep = 6u
