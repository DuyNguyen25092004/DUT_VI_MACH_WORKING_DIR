ADE simulation setup
Test my_lib_pmos_tb_1: my_lib/pmos_tb/schematic, simulator spectre
  Models: /home/dtvt_13/WORK/65NTSMC/tsmcN65/../models/spectre/crn65gplus_2d5_lk_v1d0.scs[tt_bip, tt_dio, tt_dio_33, tt_mim, tt_dio_dnw, tt_dio_18, tt_bip_npn, tt_33, tt_rfrtmom, tt_mos_cap_25, tt_18, tt_disres, tt_res, tt_dio_na, tt_rfmos_33, tt_dio_hvt, tt_rfmvar, tt_rfmos_18, tt_na, tt_dio_na33, tt_dio_lvt, tt_rfres_sa, tt_na33, tt_dio_esd, tt_rfmim, tt_dio_25od33, tt_25od33, tt, tt_mos_cap, tt_dio_25, tt_dio_25ud18, tt_25, tt_rfmos, tt_25ud18, tt_dio_na25od33, tt_rfjvar, tt_rfmos_25, tt_rtmom, tt_na25od33, tt_dio_na25, tt_rfres_rpo, tt_hvt, tt_rfind, tt_rfmvar_25, tt_na25, tt_lvt]
  Variables: l_sweep = 60n; mul = 1; vg = 0.9; vs = 1.8; w_sweep = 6u
  Temperature: 27
  Operating points saved: /M0 (vgs id gmoverid is gm gds)
  Analysis dc: sweep vg start=0 stop=1.8 (saves the operating point)
  Output gm/id = OS("/M0" "gmoverid") (unticked)
  Output id/w = ((- OS("/M0" "id")) / VAR("w_sweep")) (unticked)
  Output gm/gds = (OS("/M0" "gm") / OS("/M0" "gds")) (unticked)
  Output gm/id vs vdsat = waveVsWave(?x OS("/M0" "gmoverid") ?y OS("/M0" "vdsat"))
  Output gm/id vs gm/gds = waveVsWave(?x OS("/M0" "gmoverid") ?y (OS("/M0" "gm") / OS("/M0" "gds")))
  Output gm/id vs vgs = waveVsWave(?x OS("/M0" "gmoverid") ?y OS("/M0" "vgs"))
  Output gm/id vs id/w = waveVsWave(?x OS("/M0" "gmoverid") ?y (OS("/M0" "id") / VAR("w_sweep")))
  Output gm/id vs -id/w = waveVsWave(?x OS("/M0" "gmoverid") ?y ((- OS("/M0" "id")) / VAR("w_sweep")))
Run mode: Single Run, Sweeps and Corners
Setup values for test my_lib_pmos_tb_1: l_sweep = 0.26u:0.012u:0.38u
